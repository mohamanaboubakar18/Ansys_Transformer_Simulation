# Ansys Electronics Desktop project, version 2025.2
materials:
  vacuum: permittivity=1
  copper: permeability=0.999991 conductivity=58000000

design Maxwell3DDesign1 (Maxwell 3D, AC Magnetic, model units in)
variables:
  Lt_x = 0.2mm
  Ltx = 1in
  Lty = 2in
  Ltz = 2in
  Lcore_x = 1.1in
  Lcore_y = 0.4in
  Lcore_z = 1in
  Vm = 120V
geometry:
  Transformer_Mohaman [vacuum] = box(corner=(-Ltx/2, -Lty/2, 0in), size=(Ltx, Lty, Ltz))
  Box1 = box(corner=(-Lcore_x/2, Lcore_y/2, Lcore_z/2), size=(Lcore_x, Lcore_y, Lcore_z))
  Box2 = box(corner=(-Lcore_x/2, Lcore_y/2, Lcore_z/2), size=(Lcore_x, Lcore_y, Lcore_z))
  Box2.rotate(axis=Z, angle=180deg)
  Transformer_Mohaman.subtract(Box1, Box2)
  Rectangle1 [copper] = rectangle(corner=(0in, 0.27631926in, 1.4155543in), y_size=0.10674333in, z_size=-0.8366958in)
  Rectangle2 = rectangle(corner=(-0.78909904in, -0.51684357in, 1in), x_size=1.5028181in, y_size=1.0118318in, uncovered)
  Rectangle2.scale(0.9, 0.8, 1)
  Rectangle2.scale(0.9, 0.8, 1)
  Rectangle1.scale(1, 0.8, 1)
  Rectangle1.move(0in, 0in, 0in)
  Rectangle1.move(0in, 0.045164178in, 0.011686763in)
  Rectangle1.sweep_along_path(Rectangle2)
  Rectangle3 = rectangle(corner=(-0.03052889in, -0.28020701in, 1.427241in), y_size=-0.085394662in, z_size=-0.8366958in)
  Region [vacuum] = region(percentage_offset=20 on all sides)
boundaries and excitations:
  CoilTerminal1: Coil Terminal Objects=Rectangle3 Conductor_number=1000 Winding=Winding1 Point_out_of_terminal=false
  Winding1: Winding Group Type=Current IsSolid=false Current=100A ParallelBranchesNum=1 Phase=0deg
mesh:
  Length1: LengthBased RefineInside Objects=Rectangle1 MaxLength=0.25738525in
  Length2: LengthBased RefineInside Objects=Region MaxLength=0.56in
  initial mesh: GlobalCurvilinear{Apply}
setups:
  Setup1: AC Magnetic MaximumPasses=10 MinimumPasses=2 MinimumConvergedPasses=1 PercentRefinement=30 PercentError=1 ConstantDelta=0s NonLinearResidual=0.0001 Frequency=60Hz SweepRanges{point 10Hz} SaveAllFields LossAdaptiveCtrl=0.5
field plots:
  Vector_B2: B over a plane on Setup1 : LastAdaptive at Freq=10Hz Phase=0deg
